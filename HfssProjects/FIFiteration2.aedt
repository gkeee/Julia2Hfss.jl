# Ansys Electronics Desktop project, version 2023.2
materials:
  vacuum: permittivity=1
  pec: conductivity=1e+30
  air: permittivity=1.0006 permeability=1.0000004

design HFSSDesign1 (HFSS, HFSS Modal Network, model units mm)
variables:
  radius = 0.001mm
  portlen = 0.25mm
  radbox = 30mm
geometry:
  coordinate_system RelativeCS1 = origin=(0mm, 0mm, 0mm) x=(0mm, 0mm, 1mm) y=(0mm, -1mm, 0mm)
  FIFline [pec, oriented by RelativeCS1] = polyline(z=0mm, xy in mm: (-0.001, 0) (0, 0) (0.010005003, 0.052026013) (0.020010005, 0.10405203) (0.030015008, 0.15607804) (0.04002001, 0.20810405) (0.050025013, 0.26013007) (0.060030015, 0.31215608) (0.070035018, 0.36418209) (0.08004002, 0.4162081) (0.090045023, 0.46823412) (0.10005003, 0.52026013) (0.11005503, 0.57228614) (0.12006003, 0.62431216) (0.13006503, 0.67633817) (0.14007004, 0.72836418) (0.15007504, 0.7803902) (0.16008004, 0.83241621) (0.17008504, 0.88444222) (0.18009005, 0.93646823) (0.19009505, 0.98849425) (0.20010005, 1.0405203) (0.21010505, 1.0925463) (0.22011006, 1.1445723) (0.23011506, 1.1965983) (0.24012006, 1.2486243) (0.25012506, 1.3006503) (0.26013007, 1.3526763) (0.27013507, 1.4047024) (0.28014007, 1.4567284) (0.29014507, 1.5087544) (0.30015008, 1.5607804) (0.31015508, 1.6128064) (0.32016008, 1.6648324) (0.33016508, 1.7168584) (0.34017009, 1.7688844) (0.35017509, 1.8209105) (0.36018009, 1.8729365) (0.37018509, 1.9249625) (0.3801901, 1.9769885) (0.3901951, 2.0290145) (0.4002001, 2.0810405) (0.4102051, 2.1330665) (0.42021011, 2.1850925) (0.43021511, 2.2371186) (0.44022011, 2.2891446) (0.45022511, 2.3411706) (0.46023012, 2.3931966) (0.47023512, 2.4452226) (0.48024012, 2.4972486) (0.49024512, 2.5492746) (0.50025013, 2.6013007) (0.51025513, 2.6533267) (0.52026013, 2.7053527) (0.53026513, 2.7573787) (0.54027014, 2.8094047) (0.55027514, 2.8614307) (0.56028014, 2.9134567) (0.57028514, 2.9654827) (0.58029015, 3.0175088) (0.59029515, 3.0695348) (0.60030015, 3.1215608) (0.61030515, 3.1735868) (0.62031016, 3.2256128) (0.63031516, 3.2776388) (0.64032016, 3.3296648) (0.65032516, 3.3816908) (0.66033017, 3.4337169) (0.67033517, 3.4857429) (0.68034017, 3.5377689) (0.69034517, 3.5897949) (0.70035018, 3.6418209) (0.71035518, 3.6938469) (0.72036018, 3.7458729) (0.73036518, 3.7978989) (0.74037019, 3.849925) (0.75037519, 3.901951) (0.76038019, 3.953977) (0.77038519, 4.006003) (0.7803902, 4.058029) (0.7903952, 4.110055) (0.8004002, 4.162081) (0.8104052, 4.2141071) (0.82041021, 4.2661331) (0.83041521, 4.3181591) (0.84042021, 4.3701851) (0.85042521, 4.4222111) (0.86043022, 4.4742371) (0.87043522, 4.5262631) (0.88044022, 4.5782891) (0.89044522, 4.6303152) (0.90045023, 4.6823412) (0.91045523, 4.7343672) (0.92046023, 4.7863932) (0.93046523, 4.8384192) (0.94047024, 4.8904452) (0.95047524, 4.9424712) (0.96048024, 4.9944972) (0.97048524, 5.0465233) (0.98049025, 5.0985493) (0.99049525, 5.1505753) (1.0005003, 5.2026013) (1.0105053, 5.2546273) (1.0205103, 5.3066533) (1.0305153, 5.3586793) (1.0405203, 5.4107054) (1.0505253, 5.4627314) (1.0605303, 5.5147574) (1.0705353, 5.5667834) (1.0805403, 5.6188094) (1.0905453, 5.6708354) (1.1005503, 5.7228614) (1.1105553, 5.7748874) (1.1205603, 5.8269135) (1.1305653, 5.8789395) (1.1405703, 5.9309655) (1.1505753, 5.9829915) (1.1605803, 6.0350175) (1.1705853, 6.0870435) (1.1805903, 6.1390695) (1.1905953, 6.1910955) (1.2006003, 6.2431216) (1.2106053, 6.2951476) (1.2206103, 6.3471736) (1.2306153, 6.3991996) (1.2406203, 6.4512256) (1.2506253, 6.4992496) (1.2606303, 6.4872436) (1.2706353, 6.4752376) (1.2806403, 6.4632316) (1.2906453, 6.4512256) (1.3006503, 6.4392196) (1.3106553, 6.4272136) (1.3206603, 6.4152076) (1.3306653, 6.4032016) (1.3406703, 6.3911956) (1.3506753, 6.3791896) (1.3606803, 6.3671836) (1.3706853, 6.3551776) (1.3806903, 6.3431716) (1.3906953, 6.3311656) (1.4007004, 6.3191596) (1.4107054, 6.3071536) (1.4207104, 6.2951476) (1.4307154, 6.2831416) (1.4407204, 6.2711356) (1.4507254, 6.2591296) (1.4607304, 6.2471236) (1.4707354, 6.2351176) (1.4807404, 6.2231116) (1.4907454, 6.2111056) (1.5007504, 6.1990995) (1.5107554, 6.1870935) (1.5207604, 6.1750875) (1.5307654, 6.1630815) (1.5407704, 6.1510755) (1.5507754, 6.1390695) (1.5607804, 6.1270635) (1.5707854, 6.1150575) (1.5807904, 6.1030515) (1.5907954, 6.0910455) (1.6008004, 6.0790395) (1.6108054, 6.0670335) (1.6208104, 6.0550275) (1.6308154, 6.0430215) (1.6408204, 6.0310155) (1.6508254, 6.0190095) (1.6608304, 6.0070035) (1.6708354, 5.9949975) (1.6808404, 5.9829915) (1.6908454, 5.9709855) (1.7008504, 5.9589795) (1.7108554, 5.9469735) (1.7208604, 5.9349675) (1.7308654, 5.9229615) (1.7408704, 5.9109555) (1.7508754, 5.8989495) (1.7608804, 5.8869435) (1.7708854, 5.8749375) (1.7808904, 5.8629315) (1.7908954, 5.8509255) (1.8009005, 5.8389195) (1.8109055, 5.8269135) (1.8209105, 5.8149075) (1.8309155, 5.8029015) (1.8409205, 5.7908954) (1.8509255, 5.7788894) (1.8609305, 5.7668834) (1.8709355, 5.7548774) (1.8809405, 5.7428714) (1.8909455, 5.7308654) (1.9009505, 5.7188594) (1.9109555, 5.7068534) (1.9209605, 5.6948474) (1.9309655, 5.6828414) (1.9409705, 5.6708354) (1.9509755, 5.6588294) (1.9609805, 5.6468234) (1.9709855, 5.6348174) (1.9809905, 5.6228114) (1.9909955, 5.6108054) (2.0010005, 5.5987994) (2.0110055, 5.5867934) (2.0210105, 5.5747874) (2.0310155, 5.5627814) (2.0410205, 5.5507754) (2.0510255, 5.5387694) (2.0610305, 5.5267634) (2.0710355, 5.5147574) (2.0810405, 5.5027514) (2.0910455, 5.4907454) (2.1010505, 5.4787394) (2.1110555, 5.4667334) (2.1210605, 5.4547274) (2.1310655, 5.4427214) (2.1410705, 5.4307154) (2.1510755, 5.4187094) (2.1610805, 5.4067034) (2.1710855, 5.3946973) (2.1810905, 5.3826913) (2.1910955, 5.3706853) (2.2011006, 5.3586793) (2.2111056, 5.3466733) (2.2211106, 5.3346673) (2.2311156, 5.3226613) (2.2411206, 5.3106553) (2.2511256, 5.2986493) (2.2611306, 5.2866433) (2.2711356, 5.2746373) (2.2811406, 5.2626313) (2.2911456, 5.2506253) (2.3011506, 5.2386193) (2.3111556, 5.2266133) (2.3211606, 5.2146073) (2.3311656, 5.2026013) (2.3411706, 5.1905953) (2.3511756, 5.1785893) (2.3611806, 5.1665833) (2.3711856, 5.1545773) (2.3811906, 5.1425713) (2.3911956, 5.1305653) (2.4012006, 5.1185593) (2.4112056, 5.1065533) (2.4212106, 5.0945473) (2.4312156, 5.0825413) (2.4412206, 5.0705353) (2.4512256, 5.0585293) (2.4612306, 5.0465233) (2.4712356, 5.0345173) (2.4812406, 5.0225113) (2.4912456, 5.0105053) (2.5012506, 4.9984992) (2.5112556, 4.9864932) (2.5212606, 4.9744872) (2.5312656, 4.9624812) (2.5412706, 4.9504752) (2.5512756, 4.9384692) (2.5612806, 4.9264632) (2.5712856, 4.9144572) (2.5812906, 4.9024512) (2.5912956, 4.8904452) (2.6013007, 4.8784392) (2.6113057, 4.8664332) (2.6213107, 4.8544272) (2.6313157, 4.8424212) (2.6413207, 4.8304152) (2.6513257, 4.8184092) (2.6613307, 4.8064032) (2.6713357, 4.7943972) (2.6813407, 4.7823912) (2.6913457, 4.7703852) (2.7013507, 4.7583792) (2.7113557, 4.7463732) (2.7213607, 4.7343672) (2.7313657, 4.7223612) (2.7413707, 4.7103552) (2.7513757, 4.6983492) (2.7613807, 4.6863432) (2.7713857, 4.6743372) (2.7813907, 4.6623312) (2.7913957, 4.6503252) (2.8014007, 4.6383192) (2.8114057, 4.6263132) (2.8214107, 4.6143072) (2.8314157, 4.6023012) (2.8414207, 4.5902951) (2.8514257, 4.5782891) (2.8614307, 4.5662831) (2.8714357, 4.5542771) (2.8814407, 4.5422711) (2.8914457, 4.5302651) (2.9014507, 4.5182591) (2.9114557, 4.5062531) (2.9214607, 4.4942471) (2.9314657, 4.4822411) (2.9414707, 4.4702351) (2.9514757, 4.4582291) (2.9614807, 4.4462231) (2.9714857, 4.4342171) (2.9814907, 4.4222111)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, section circle width=2*radius bend_type=Curved)
  Rectangle1 [oriented by RelativeCS1] = rectangle(corner=(-radius, -radius, 0mm), x_size=-portlen, y_size=2*radius)
  Box1 [air, oriented by RelativeCS1] = box(corner=(-radius-portlen, -radbox, -radbox), size=(radbox, 2*radbox, 2*radbox))
boundaries and excitations:
  Rad1: Radiation Faces=Box1.face(+x, +y, -y, +z, -z)
  Sym1: Symmetry Faces=Box1.face(-x) IsPerfectE=true
  1: Lumped Port Objects=Rectangle1 LumpedPortType=Modal Modes{Mode1{IntLine{(-0.251, 0, 0) -> (-0.001, 0, 0)} CharImp=Zpi}} Impedance=50ohm
setups:
  Setup1: HfssDriven Frequency=12GHz MaxDeltaS=0.02 MaximumPasses=6 MinimumPasses=1 MinimumConvergedPasses=1 PercentRefinement=30 BasisOrder=1 PortAccuracy=2 DrivenSolverType="Direct Solver"
    sweep Sweep: 0.01GHz to 12GHz, 401 points; Type=Discrete
  Setup2: HfssDrivenAuto AutoSolverSetting="Higher Speed" Type=Discrete
    sweep Sweep: point 1.4488GHz; point 3.9367GHz; point 6.2448GHz; point 8.403GHz; point 10.4113GHz;
source amplitudes:
  1:1: 1V 0deg
radiation setups:
  Infinite Sphere1: Infinite Sphere Theta=-180deg..180deg step 2deg Phi=-180deg..180deg step 2deg
reports:
  S Parameter Plot 1: dB(S(1,1)) vs Freq on Setup1 : Sweep; markers m1 at 1.4488GHz, m2 at 3.936725GHz, m3 at 6.2448GHz, m4 at 8.403GHz, m5 at 10.411325GHz
  Gain Plot 1: dB(GainTotal) vs Theta on Setup2 : Sweep, Infinite Sphere1 [Phi=0deg,90deg Freq=1.4488GHz]
  Gain Plot 2: dB(GainTotal) vs Theta on Setup2 : Sweep, Infinite Sphere1 [Phi=0deg,90deg Freq=3.9367GHz]
  Gain Plot 3: dB(GainTotal) vs Theta on Setup2 : Sweep, Infinite Sphere1 [Phi=0deg,90deg Freq=6.2448GHz]
  Gain Plot 4: dB(GainTotal) vs Theta on Setup2 : Sweep, Infinite Sphere1 [Phi=0deg,90deg Freq=8.403GHz]
  Gain Plot 5: dB(GainTotal) vs Theta on Setup2 : Sweep, Infinite Sphere1 [Phi=0deg,90deg Freq=10.4113GHz]
  Gain Plot 6: dB(GainTotal) vs Phi on Setup2 : Sweep, Infinite Sphere1 [Theta=90deg Freq=1.4488GHz]
  Gain Plot 7: dB(GainTotal) vs Phi on Setup2 : Sweep, Infinite Sphere1 [Theta=90deg Freq=3.9367GHz]
  Gain Plot 8: dB(GainTotal) vs Phi on Setup2 : Sweep, Infinite Sphere1 [Theta=90deg Freq=6.2448GHz]
  Gain Plot 9: dB(GainTotal) vs Phi on Setup2 : Sweep, Infinite Sphere1 [Theta=90deg Freq=8.403GHz]
  Gain Plot 10: dB(GainTotal) vs Phi on Setup2 : Sweep, Infinite Sphere1 [Theta=90deg Freq=10.4113GHz]
  Gain Plot 11: dB(GainTotal) vs Phi, Theta on Setup2 : Sweep, Infinite Sphere1 [Freq=1.4488GHz]
  Gain Plot 12: dB(GainTotal) vs Phi, Theta on Setup2 : Sweep, Infinite Sphere1 [Freq=3.9367GHz]
  Gain Plot 13: dB(GainTotal) vs Phi, Theta on Setup2 : Sweep, Infinite Sphere1 [Freq=6.2448GHz]
  Gain Plot 14: dB(GainTotal) vs Phi, Theta on Setup2 : Sweep, Infinite Sphere1 [Freq=8.403GHz]
  Gain Plot 15: dB(GainTotal) vs Phi, Theta on Setup2 : Sweep, Infinite Sphere1 [Freq=10.4113GHz]

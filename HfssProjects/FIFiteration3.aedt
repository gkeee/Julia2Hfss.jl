# Ansys Electronics Desktop project, version 2023.2
materials:
  vacuum: permittivity=1
  pec: conductivity=1e+30
  air: permittivity=1.0006 permeability=1.0000004

design HFSSDesign1 (HFSS, HFSS Modal Network, model units mm)
variables:
  radius = 0.001mm
  portlen = 0.25mm
  radbox = 30mm
geometry:
  coordinate_system RelativeCS1 = origin=(0mm, 0mm, 0mm) x=(0mm, 0mm, 1mm) y=(0mm, -1mm, 0mm)
  FIFline [pec, oriented by RelativeCS1] = polyline(z=0mm, xy in mm: (-0.001, 0) (0, 0) (0.010005003, 0.10325163) (0.020010005, 0.20650325) (0.030015008, 0.30975488) (0.04002001, 0.4130065) (0.050025013, 0.51625813) (0.060030015, 0.61950975) (0.070035018, 0.72276138) (0.08004002, 0.82601301) (0.090045023, 0.92926463) (0.10005003, 1.0325163) (0.11005503, 1.1357679) (0.12006003, 1.2390195) (0.13006503, 1.3422711) (0.14007004, 1.4455228) (0.15007504, 1.5487744) (0.16008004, 1.652026) (0.17008504, 1.7552776) (0.18009005, 1.8585293) (0.19009505, 1.9617809) (0.20010005, 2.0650325) (0.21010505, 2.1682841) (0.22011006, 2.2715358) (0.23011506, 2.3747874) (0.24012006, 2.478039) (0.25012506, 2.5812906) (0.26013007, 2.6845423) (0.27013507, 2.7877939) (0.28014007, 2.8910455) (0.29014507, 2.9942971) (0.30015008, 3.0975488) (0.31015508, 3.2008004) (0.32016008, 3.2256128) (0.33016508, 3.2264132) (0.34017009, 3.2272136) (0.35017509, 3.228014) (0.36018009, 3.2288144) (0.37018509, 3.2296148) (0.3801901, 3.2304152) (0.3901951, 3.2312156) (0.4002001, 3.232016) (0.4102051, 3.2328164) (0.42021011, 3.2336168) (0.43021511, 3.2344172) (0.44022011, 3.2352176) (0.45022511, 3.236018) (0.46023012, 3.2368184) (0.47023512, 3.2376188) (0.48024012, 3.2384192) (0.49024512, 3.2392196) (0.50025013, 3.24002) (0.51025513, 3.2408204) (0.52026013, 3.2416208) (0.53026513, 3.2424212) (0.54027014, 3.2432216) (0.55027514, 3.244022) (0.56028014, 3.2448224) (0.57028514, 3.2456228) (0.58029015, 3.2464232) (0.59029515, 3.2472236) (0.60030015, 3.248024) (0.61030515, 3.2488244) (0.62031016, 3.2496248) (0.63031516, 3.2504252) (0.64032016, 3.2512256) (0.65032516, 3.252026) (0.66033017, 3.2528264) (0.67033517, 3.2536268) (0.68034017, 3.2544272) (0.69034517, 3.2552276) (0.70035018, 3.256028) (0.71035518, 3.2568284) (0.72036018, 3.2576288) (0.73036518, 3.2584292) (0.74037019, 3.2592296) (0.75037519, 3.26003) (0.76038019, 3.2608304) (0.77038519, 3.2616308) (0.7803902, 3.2624312) (0.7903952, 3.2632316) (0.8004002, 3.264032) (0.8104052, 3.2648324) (0.82041021, 3.2656328) (0.83041521, 3.2664332) (0.84042021, 3.2672336) (0.85042521, 3.268034) (0.86043022, 3.2688344) (0.87043522, 3.2696348) (0.88044022, 3.2704352) (0.89044522, 3.2712356) (0.90045023, 3.272036) (0.91045523, 3.2728364) (0.92046023, 3.2736368) (0.93046523, 3.2744372) (0.94047024, 3.3056528) (0.95047524, 3.4089045) (0.96048024, 3.5121561) (0.97048524, 3.6154077) (0.98049025, 3.7186593) (0.99049525, 3.821911) (1.0005003, 3.9251626) (1.0105053, 4.0284142) (1.0205103, 4.1316658) (1.0305153, 4.2349175) (1.0405203, 4.3381691) (1.0505253, 4.4414207) (1.0605303, 4.5446723) (1.0705353, 4.647924) (1.0805403, 4.7511756) (1.0905453, 4.8544272) (1.1005503, 4.9576788) (1.1105553, 5.0609305) (1.1205603, 5.1641821) (1.1305653, 5.2674337) (1.1405703, 5.3706853) (1.1505753, 5.473937) (1.1605803, 5.5771886) (1.1705853, 5.6804402) (1.1805903, 5.7836918) (1.1905953, 5.8869435) (1.2006003, 5.9901951) (1.2106053, 6.0934467) (1.2206103, 6.1966983) (1.2306153, 6.29995) (1.2406203, 6.4032016) (1.2506253, 6.5024512) (1.2606303, 6.5416708) (1.2706353, 6.5808904) (1.2806403, 6.6201101) (1.2906453, 6.6593297) (1.3006503, 6.6985493) (1.3106553, 6.7377689) (1.3206603, 6.7769885) (1.3306653, 6.8162081) (1.3406703, 6.8554277) (1.3506753, 6.8946473) (1.3606803, 6.9338669) (1.3706853, 6.9730865) (1.3806903, 7.0123062) (1.3906953, 7.0515258) (1.4007004, 7.0907454) (1.4107054, 7.129965) (1.4207104, 7.1691846) (1.4307154, 7.2084042) (1.4407204, 7.2476238) (1.4507254, 7.2868434) (1.4607304, 7.326063) (1.4707354, 7.3652826) (1.4807404, 7.4045023) (1.4907454, 7.4437219) (1.5007504, 7.4829415) (1.5107554, 7.5221611) (1.5207604, 7.5613807) (1.5307654, 7.6006003) (1.5407704, 7.6398199) (1.5507754, 7.6790395) (1.5607804, 7.7182591) (1.5707854, 7.6726363) (1.5807904, 7.6094047) (1.5907954, 7.5461731) (1.6008004, 7.4829415) (1.6108054, 7.4197099) (1.6208104, 7.3564782) (1.6308154, 7.2932466) (1.6408204, 7.230015) (1.6508254, 7.1667834) (1.6608304, 7.1035518) (1.6708354, 7.0403202) (1.6808404, 6.9770885) (1.6908454, 6.9138569) (1.7008504, 6.8506253) (1.7108554, 6.7873937) (1.7208604, 6.7241621) (1.7308654, 6.6609305) (1.7408704, 6.5976988) (1.7508754, 6.5344672) (1.7608804, 6.4712356) (1.7708854, 6.408004) (1.7808904, 6.3447724) (1.7908954, 6.2815408) (1.8009005, 6.2183092) (1.8109055, 6.1550775) (1.8209105, 6.0918459) (1.8309155, 6.0286143) (1.8409205, 5.9653827) (1.8509255, 5.9021511) (1.8609305, 5.8389195) (1.8709355, 5.7756878) (1.8809405, 5.7124562) (1.8909455, 5.6492246) (1.9009505, 5.585993) (1.9109555, 5.5227614) (1.9209605, 5.4595298) (1.9309655, 5.3962981) (1.9409705, 5.3330665) (1.9509755, 5.2698349) (1.9609805, 5.2066033) (1.9709855, 5.1433717) (1.9809905, 5.0801401) (1.9909955, 5.0169085) (2.0010005, 4.9536768) (2.0110055, 4.8904452) (2.0210105, 4.8272136) (2.0310155, 4.763982) (2.0410205, 4.7007504) (2.0510255, 4.6375188) (2.0610305, 4.5742871) (2.0710355, 4.5110555) (2.0810405, 4.4478239) (2.0910455, 4.3845923) (2.1010505, 4.3213607) (2.1110555, 4.2581291) (2.1210605, 4.1948974) (2.1310655, 4.1316658) (2.1410705, 4.0684342) (2.1510755, 4.0052026) (2.1610805, 3.941971) (2.1710855, 3.8787394) (2.1810905, 3.8155078) (2.1910955, 3.7890945) (2.2011006, 3.8283142) (2.2111056, 3.8675338) (2.2211106, 3.9067534) (2.2311156, 3.945973) (2.2411206, 3.9851926) (2.2511256, 4.0244122) (2.2611306, 4.0636318) (2.2711356, 4.1028514) (2.2811406, 4.142071) (2.2911456, 4.1812906) (2.3011506, 4.2205103) (2.3111556, 4.2597299) (2.3211606, 4.2989495) (2.3311656, 4.3381691) (2.3411706, 4.3773887) (2.3511756, 4.4166083) (2.3611806, 4.4558279) (2.3711856, 4.4950475) (2.3811906, 4.5342671) (2.3911956, 4.5734867) (2.4012006, 4.6127064) (2.4112056, 4.651926) (2.4212106, 4.6911456) (2.4312156, 4.7303652) (2.4412206, 4.7695848) (2.4512256, 4.8088044) (2.4612306, 4.848024) (2.4712356, 4.8872436) (2.4812406, 4.9264632) (2.4912456, 4.9656828) (2.5012506, 5.0049025) (2.5112556, 5.0441221) (2.5212606, 5.0833417) (2.5312656, 5.1225613) (2.5412706, 5.1617809) (2.5512756, 5.2010005) (2.5612806, 5.2402201) (2.5712856, 5.2794397) (2.5812906, 5.3186593) (2.5912956, 5.3578789) (2.6013007, 5.3970985) (2.6113057, 5.4363182) (2.6213107, 5.4755378) (2.6313157, 5.5147574) (2.6413207, 5.553977) (2.6513257, 5.5931966) (2.6613307, 5.6324162) (2.6713357, 5.6716358) (2.6813407, 5.7108554) (2.6913457, 5.750075) (2.7013507, 5.7892946) (2.7113557, 5.8285143) (2.7213607, 5.8677339) (2.7313657, 5.9069535) (2.7413707, 5.9461731) (2.7513757, 5.9853927) (2.7613807, 6.0246123) (2.7713857, 6.0638319) (2.7813907, 6.1030515) (2.7913957, 6.1422711) (2.8014007, 6.1814907) (2.8114057, 6.2207104) (2.8214107, 6.1686843) (2.8314157, 6.1054527) (2.8414207, 6.0422211) (2.8514257, 5.9789895) (2.8614307, 5.9157579) (2.8714357, 5.8525263) (2.8814407, 5.7892946) (2.8914457, 5.726063) (2.9014507, 5.6628314) (2.9114557, 5.5995998) (2.9214607, 5.5363682) (2.9314657, 5.4731366) (2.9414707, 5.409905) (2.9514757, 5.3466733) (2.9614807, 5.2834417) (2.9714857, 5.2202101) (2.9814907, 5.1569785)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, section circle width=2*radius bend_type=Curved)
  Rectangle1 [oriented by RelativeCS1] = rectangle(corner=(-radius, -radius, 0mm), x_size=-portlen, y_size=2*radius)
  Box1 [air, oriented by RelativeCS1] = box(corner=(-radius-portlen, -radbox, -radbox), size=(radbox, 2*radbox, 2*radbox))
boundaries and excitations:
  Rad1: Radiation Faces=Box1.face(+x, -y, +y, -z, +z)
  Sym1: Symmetry Faces=Box1.face(-x) IsPerfectE=true
  1: Lumped Port Objects=Rectangle1 LumpedPortType=Modal Modes{Mode1{IntLine{(-0.251, 0, 0) -> (-0.001, 0, 0)} CharImp=Zpi RenormImp=50ohm}} Impedance=50ohm
setups:
  Setup1: HfssDriven Frequency=12GHz MaxDeltaS=0.02 MaximumPasses=6 MinimumPasses=1 MinimumConvergedPasses=1 PercentRefinement=30 BasisOrder=1 PortAccuracy=2 DrivenSolverType="Direct Solver"
    sweep Sweep: 0.01GHz to 12GHz, 401 points; Type=Discrete
source amplitudes:
  1:1: 0.5W 0deg
radiation setups:
  Infinite Sphere1: Infinite Sphere Theta=-180deg..180deg step 2deg Phi=-180deg..180deg step 2deg

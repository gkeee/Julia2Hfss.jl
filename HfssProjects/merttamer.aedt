# Ansys Electronics Desktop project, version 2023.2
materials:
  vacuum: permittivity=1
  pec: conductivity=1e+30
  air: permittivity=1.0006 permeability=1.0000004

design HFSSDesign1 (HFSS, HFSS Modal Network, model units mm)
variables:
  radius = 0.01mm
  portlen = 0.25mm
  radbox = 30mm
geometry:
  coordinate_system RelativeCS1 = origin=(0mm, 0mm, 0mm) x=(0mm, 0mm, 1mm) y=(0mm, -1mm, 0mm)
  FIFline [pec, oriented by RelativeCS1] = polyline(z=0mm, xy in mm: (-0.01, 0) (0, 0) (0.010005003, 0.020010005) (0.020010005, 0.04002001) (0.030015008, 0.060030015) (0.04002001, 0.08004002) (0.050025013, 0.10005003) (0.060030015, 0.12006003) (0.070035018, 0.14007004) (0.08004002, 0.16008004) (0.090045023, 0.18009005) (0.10005003, 0.20010005) (0.11005503, 0.22011006) (0.12006003, 0.24012006) (0.13006503, 0.26013007) (0.14007004, 0.28014007) (0.15007504, 0.30015008) (0.16008004, 0.32016008) (0.17008504, 0.34017009) (0.18009005, 0.36018009) (0.19009505, 0.3801901) (0.20010005, 0.4002001) (0.21010505, 0.42021011) (0.22011006, 0.44022011) (0.23011506, 0.46023012) (0.24012006, 0.48024012) (0.25012506, 0.50025013) (0.26013007, 0.52026013) (0.27013507, 0.54027014) (0.28014007, 0.56028014) (0.29014507, 0.58029015) (0.30015008, 0.60030015) (0.31015508, 0.62031016) (0.32016008, 0.64032016) (0.33016508, 0.66033017) (0.34017009, 0.68034017) (0.35017509, 0.70035018) (0.36018009, 0.72036018) (0.37018509, 0.74037019) (0.3801901, 0.76038019) (0.3901951, 0.7803902) (0.4002001, 0.8004002) (0.4102051, 0.82041021) (0.42021011, 0.84042021) (0.43021511, 0.86043022) (0.44022011, 0.88044022) (0.45022511, 0.90045023) (0.46023012, 0.92046023) (0.47023512, 0.94047024) (0.48024012, 0.96048024) (0.49024512, 0.98049025) (0.50025013, 1.0005003) (0.51025513, 1.0205103) (0.52026013, 1.0405203) (0.53026513, 1.0605303) (0.54027014, 1.0805403) (0.55027514, 1.1005503) (0.56028014, 1.1205603) (0.57028514, 1.1405703) (0.58029015, 1.1605803) (0.59029515, 1.1805903) (0.60030015, 1.2006003) (0.61030515, 1.2206103) (0.62031016, 1.2406203) (0.63031516, 1.2606303) (0.64032016, 1.2806403) (0.65032516, 1.3006503) (0.66033017, 1.3206603) (0.67033517, 1.3406703) (0.68034017, 1.3606803) (0.69034517, 1.3806903) (0.70035018, 1.4007004) (0.71035518, 1.4207104) (0.72036018, 1.4407204) (0.73036518, 1.4607304) (0.74037019, 1.4807404) (0.75037519, 1.5007504) (0.76038019, 1.5207604) (0.77038519, 1.5407704) (0.7803902, 1.5607804) (0.7903952, 1.5807904) (0.8004002, 1.6008004) (0.8104052, 1.6208104) (0.82041021, 1.6408204) (0.83041521, 1.6608304) (0.84042021, 1.6808404) (0.85042521, 1.7008504) (0.86043022, 1.7208604) (0.87043522, 1.7408704) (0.88044022, 1.7608804) (0.89044522, 1.7808904) (0.90045023, 1.8009005) (0.91045523, 1.8209105) (0.92046023, 1.8409205) (0.93046523, 1.8609305) (0.94047024, 1.8809405) (0.95047524, 1.9009505) (0.96048024, 1.9209605) (0.97048524, 1.9409705) (0.98049025, 1.9609805) (0.99049525, 1.9809905) (1.0005003, 2.0010005) (1.0105053, 2.0210105) (1.0205103, 2.0410205) (1.0305153, 2.0610305) (1.0405203, 2.0810405) (1.0505253, 2.1010505) (1.0605303, 2.1210605) (1.0705353, 2.1410705) (1.0805403, 2.1610805) (1.0905453, 2.1810905) (1.1005503, 2.2011006) (1.1105553, 2.2211106) (1.1205603, 2.2411206) (1.1305653, 2.2611306) (1.1405703, 2.2811406) (1.1505753, 2.3011506) (1.1605803, 2.3211606) (1.1705853, 2.3411706) (1.1805903, 2.3611806) (1.1905953, 2.3811906) (1.2006003, 2.4012006) (1.2106053, 2.4212106) (1.2206103, 2.4412206) (1.2306153, 2.4612306) (1.2406203, 2.4812406) (1.2506253, 2.5012506) (1.2606303, 2.5212606) (1.2706353, 2.5412706) (1.2806403, 2.5612806) (1.2906453, 2.5812906) (1.3006503, 2.6013007) (1.3106553, 2.6213107) (1.3206603, 2.6413207) (1.3306653, 2.6613307) (1.3406703, 2.6813407) (1.3506753, 2.7013507) (1.3606803, 2.7213607) (1.3706853, 2.7413707) (1.3806903, 2.7613807) (1.3906953, 2.7813907) (1.4007004, 2.8014007) (1.4107054, 2.8214107) (1.4207104, 2.8414207) (1.4307154, 2.8614307) (1.4407204, 2.8814407) (1.4507254, 2.9014507) (1.4607304, 2.9214607) (1.4707354, 2.9414707) (1.4807404, 2.9614807) (1.4907454, 2.9814907) (1.5007504, 3.0015008) (1.5107554, 3.0215108) (1.5207604, 3.0415208) (1.5307654, 3.0615308) (1.5407704, 3.0815408) (1.5507754, 3.1015508) (1.5607804, 3.1215608) (1.5707854, 3.1415708) (1.5807904, 3.1615808) (1.5907954, 3.1815908) (1.6008004, 3.2016008) (1.6108054, 3.2216108) (1.6208104, 3.2416208) (1.6308154, 3.2616308) (1.6408204, 3.2816408) (1.6508254, 3.3016508) (1.6608304, 3.3216608) (1.6708354, 3.3416708) (1.6808404, 3.3616808) (1.6908454, 3.3816908) (1.7008504, 3.4017009) (1.7108554, 3.4217109) (1.7208604, 3.4417209) (1.7308654, 3.4617309) (1.7408704, 3.4817409) (1.7508754, 3.5017509) (1.7608804, 3.5217609) (1.7708854, 3.5417709) (1.7808904, 3.5617809) (1.7908954, 3.5817909) (1.8009005, 3.6018009) (1.8109055, 3.6218109) (1.8209105, 3.6418209) (1.8309155, 3.6618309) (1.8409205, 3.6818409) (1.8509255, 3.7018509) (1.8609305, 3.7218609) (1.8709355, 3.7418709) (1.8809405, 3.7618809) (1.8909455, 3.7818909) (1.9009505, 3.801901) (1.9109555, 3.821911) (1.9209605, 3.841921) (1.9309655, 3.861931) (1.9409705, 3.881941) (1.9509755, 3.901951) (1.9609805, 3.921961) (1.9709855, 3.941971) (1.9809905, 3.961981) (1.9909955, 3.981991) (2.0010005, 4.002001) (2.0110055, 4.022011) (2.0210105, 4.042021) (2.0310155, 4.062031) (2.0410205, 4.082041) (2.0510255, 4.102051) (2.0610305, 4.122061) (2.0710355, 4.142071) (2.0810405, 4.162081) (2.0910455, 4.182091) (2.1010505, 4.2021011) (2.1110555, 4.2221111) (2.1210605, 4.2421211) (2.1310655, 4.2621311) (2.1410705, 4.2821411) (2.1510755, 4.3021511) (2.1610805, 4.3221611) (2.1710855, 4.3421711) (2.1810905, 4.3621811) (2.1910955, 4.3821911) (2.2011006, 4.4022011) (2.2111056, 4.4222111) (2.2211106, 4.4422211) (2.2311156, 4.4622311) (2.2411206, 4.4822411) (2.2511256, 4.5022511) (2.2611306, 4.5222611) (2.2711356, 4.5422711) (2.2811406, 4.5622811) (2.2911456, 4.5822911) (2.3011506, 4.6023012) (2.3111556, 4.6223112) (2.3211606, 4.6423212) (2.3311656, 4.6623312) (2.3411706, 4.6823412) (2.3511756, 4.7023512) (2.3611806, 4.7223612) (2.3711856, 4.7423712) (2.3811906, 4.7623812) (2.3911956, 4.7823912) (2.4012006, 4.8024012) (2.4112056, 4.8224112) (2.4212106, 4.8424212) (2.4312156, 4.8624312) (2.4412206, 4.8824412) (2.4512256, 4.9024512) (2.4612306, 4.9224612) (2.4712356, 4.9424712) (2.4812406, 4.9624812) (2.4912456, 4.9824912) (2.5012506, 5.0025013) (2.5112556, 5.0225113) (2.5212606, 5.0425213) (2.5312656, 5.0625313) (2.5412706, 5.0825413) (2.5512756, 5.1025513) (2.5612806, 5.1225613) (2.5712856, 5.1425713) (2.5812906, 5.1625813) (2.5912956, 5.1825913) (2.6013007, 5.2026013) (2.6113057, 5.2226113) (2.6213107, 5.2426213) (2.6313157, 5.2626313) (2.6413207, 5.2826413) (2.6513257, 5.3026513) (2.6613307, 5.3226613) (2.6713357, 5.3426713) (2.6813407, 5.3626813) (2.6913457, 5.3826913) (2.7013507, 5.4027014) (2.7113557, 5.4227114) (2.7213607, 5.4427214) (2.7313657, 5.4627314) (2.7413707, 5.4827414) (2.7513757, 5.5027514) (2.7613807, 5.5227614) (2.7713857, 5.5427714) (2.7813907, 5.5627814) (2.7913957, 5.5827914) (2.8014007, 5.6028014) (2.8114057, 5.6228114) (2.8214107, 5.6428214) (2.8314157, 5.6628314) (2.8414207, 5.6828414) (2.8514257, 5.7028514) (2.8614307, 5.7228614) (2.8714357, 5.7428714) (2.8814407, 5.7628814) (2.8914457, 5.7828914) (2.9014507, 5.8029015) (2.9114557, 5.8229115) (2.9214607, 5.8429215) (2.9314657, 5.8629315) (2.9414707, 5.8829415) (2.9514757, 5.9029515) (2.9614807, 5.9229615) (2.9714857, 5.9429715) (2.9814907, 5.9629815)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, section circle width=2*radius bend_type=Curved)
  Rectangle1 [oriented by RelativeCS1] = rectangle(corner=(-radius, -radius, 0), x_size=-portlen, y_size=2*radius)
  Box1 [air, oriented by RelativeCS1] = box(corner=(-radius - portlen, -radbox, -radbox), size=(radbox, 2*radbox, 2*radbox))
boundaries and excitations:
  Sym1: Symmetry Faces=Box1.face(-x) IsPerfectE=true
  Rad1: Radiation Faces=Box1.face(+y, +z, +x, -y, -z)
  1: Lumped Port Objects=Rectangle1 LumpedPortType=Default Modes{Mode1{IntLine{(-0.26, 0, 0) -> (-0.01, 0, 0)} CharImp=Zpi RenormImp=50ohm}} Impedance=50ohm
setups:
  Setup1: HfssDriven Frequency=12GHz MaxDeltaS=0.02 MaximumPasses=6 MinimumPasses=1 MinimumConvergedPasses=1 PercentRefinement=30 BasisOrder=1 PortAccuracy=2 DrivenSolverType="Direct Solver"
    sweep Sweep: 0.01GHz to 12GHz, 401 points; Type=Discrete
  Setup2: HfssDrivenAuto AutoSolverSetting=Balanced Type=Discrete
    sweep Sweep: point 1.8684GHz; point 5.3156GHz;
source amplitudes:
  1:1: 1W 0deg
radiation setups:
  Infinite Sphere1: Infinite Sphere Theta=-180deg..180deg step 2deg Phi=-180deg..180deg step 2deg
reports:
  S Parameter Plot 1: dB(S(1,1)) vs Freq on Setup1 : Sweep; markers m1 at 1.86845GHz, m2 at 5.315575GHz, m3 at 8.612825GHz
  Gain Plot 1: dB(GainTotal) vs Theta on Setup2 : Sweep, Infinite Sphere1 [Phi=0deg,90deg Freq=1.8684GHz]
  Gain Plot 2: dB(GainTotal) vs Theta on Setup2 : Sweep, Infinite Sphere1 [Phi=0deg,90deg Freq=5.3156GHz]
  Gain Plot 3: dB(GainTotal) vs Phi on Setup2 : Sweep, Infinite Sphere1 [Theta=90deg Freq=1.8684GHz]
  Gain Plot 4: dB(GainTotal) vs Phi on Setup2 : Sweep, Infinite Sphere1 [Theta=90deg Freq=5.3156GHz]
  Gain Plot 5: dB(GainTotal) vs Phi, Theta on Setup2 : Sweep, Infinite Sphere1 [Freq=1.8684GHz]
  Gain Plot 6: dB(GainTotal) vs Phi, Theta on Setup2 : Sweep, Infinite Sphere1 [Freq=5.3156GHz]
